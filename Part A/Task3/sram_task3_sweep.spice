* AMCAS TakeHomeLab - 6T read, VDD sweep for Task 3
.include 45nm_bulk.txt $ PTM BSIM4 card
.param VDD=1.1
Vdd vdd 0 'VDD'
Vwl wl 0 PWL(0 0 1n 0 1.05n 'VDD')
MP1 qb q vdd vdd pmos W=0.15u L=0.045u
MN1 qb q 0 0 nmos W=0.20u L=0.045u
MP2 q qb vdd vdd pmos W=0.15u L=0.045u
MN2 q qb 0 0 nmos W=0.20u L=0.045u
MA1 bl wl q 0 nmos W=0.16u L=0.045u
MA2 blb wl qb 0 nmos W=0.16u L=0.045u
Cbl bl 0 180f IC='VDD'
Cblb blb 0 180f IC='VDD'
.ic v(q)=0 v(qb)='VDD'
.control
  set color0=white
  echo "VDD_V dV_V" > task3_sweep_results.txt
  foreach vddval 1.1 1.05 1.0 0.95 0.9 0.85 0.8 0.75 0.7 0.65 0.6
    alterparam VDD = $vddval
    reset
    tran 5p 4n uic
    let dv_vec = v(blb) - v(bl)
    meas tran dv_meas FIND dv_vec AT=2.0n
    echo "$vddval $&dv_meas" >> task3_sweep_results.txt
  end
.endc
.end
